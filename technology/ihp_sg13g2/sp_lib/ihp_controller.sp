* ------------------------------------------------------
*
*		Copyright 2025 IHP PDK Authors
*
*		Licensed under the Apache License, Version 2.0 (the "License");
*		you may not use this file except in compliance with the License.
*		You may obtain a copy of the License at
*
*		   https://www.apache.org/licenses/LICENSE-2.0
*
*		Unless required by applicable law or agreed to in writing, software
*		distributed under the License is distributed on an "AS IS" BASIS,
*		WITHOUT WARRANTIES OR CONDITIONS OF ANY KIND, either express or implied.
*		See the License for the specific language governing permissions and
*		limitations under the License.
*
*		Generated on Thu Jul 30 11:38:32 2026
*
* ------------------------------------------------------
* Flattened from RM_IHPSG13_64x16_c2_1P_CTRL; unchanged W/L/m.
.subckt ihp_controller aclk_n bist_clk bist_cs bist_en bist_re bist_we tie_low clk cs dclk eclk pulse_h pulse_l pulse rclk re row_cs wclk we vdd gnd
Xinternal_XI17_MN0 internal_col_we internal_XI17_QIN_SL gnd gnd sg13_lv_nmos w=980.00n l=130.00n m=1
Xinternal_XI17_MN10 internal_XI17_QIN_SL internal_XI17_CNN internal_XI17_net21 gnd sg13_lv_nmos w=850.00n l=130.00n m=1
Xinternal_XI17_MN11 internal_XI17_net21 internal_XI17_QI_MS gnd gnd sg13_lv_nmos w=850.00n l=130.00n m=1
Xinternal_XI17_MN7 internal_XI17_net30 internal_XI17_QI_MS gnd gnd sg13_lv_nmos w=480.00n l=130.00n m=1
Xinternal_XI17_MN6 internal_XI17_QIN_MS internal_XI17_CNN internal_XI17_net30 gnd sg13_lv_nmos w=480.00n l=130.00n m=1
Xinternal_XI17_MN3 internal_XI17_QI_MS internal_XI17_QIN_MS gnd gnd sg13_lv_nmos w=480.00n l=130.00n m=1
Xinternal_XI17_MN12 internal_XI17_CNN internal_ck_regs gnd gnd sg13_lv_nmos w=495.000n l=130.00n m=1
Xinternal_XI17_MN9 internal_XI17_net37 internal_we gnd gnd sg13_lv_nmos w=870.00n l=130.00n m=1
Xinternal_XI17_MN8 internal_XI17_QIN_MS internal_ck_regs internal_XI17_net37 gnd sg13_lv_nmos w=870.00n l=130.00n m=1
Xinternal_XI17_MN5 internal_XI17_QIN_SL internal_ck_regs internal_XI17_net25 gnd sg13_lv_nmos w=480.00n l=130.00n m=1
Xinternal_XI17_MN4 internal_XI17_net25 internal_XI17_QI_SL gnd gnd sg13_lv_nmos w=480.00n l=130.00n m=1
Xinternal_XI17_MN2 internal_XI17_QI_SL internal_XI17_QIN_SL gnd gnd sg13_lv_nmos w=480.00n l=130.00n m=1
Xinternal_XI17_MP0 internal_col_we internal_XI17_QIN_SL vdd vdd sg13_lv_pmos w=1.62u l=130.00n m=1
Xinternal_XI17_MP6 internal_XI17_QI_MS internal_XI17_QIN_MS vdd vdd sg13_lv_pmos w=480.00n l=130.00n m=1
Xinternal_XI17_MP3 internal_XI17_QIN_SL internal_XI17_CNN internal_XI17_net27 vdd sg13_lv_pmos w=480.00n l=130.00n m=1
Xinternal_XI17_MP2 internal_XI17_net27 internal_XI17_QI_SL vdd vdd sg13_lv_pmos w=480.00n l=130.00n m=1
Xinternal_XI17_MP10 internal_XI17_net36 internal_we vdd vdd sg13_lv_pmos w=975.000n l=130.00n m=1
Xinternal_XI17_MP11 internal_XI17_QIN_MS internal_XI17_CNN internal_XI17_net36 vdd sg13_lv_pmos w=975.000n l=130.00n m=1
Xinternal_XI17_MP4 internal_XI17_net32 internal_XI17_QI_MS vdd vdd sg13_lv_pmos w=480.00n l=130.00n m=1
Xinternal_XI17_MP5 internal_XI17_QIN_MS internal_ck_regs internal_XI17_net32 vdd sg13_lv_pmos w=480.00n l=130.00n m=1
Xinternal_XI17_MP7 internal_XI17_QI_SL internal_XI17_QIN_SL vdd vdd sg13_lv_pmos w=480.00n l=130.00n m=1
Xinternal_XI17_MP12 internal_XI17_CNN internal_ck_regs vdd vdd sg13_lv_pmos w=480.00n l=130.00n m=1
Xinternal_XI17_MP9 internal_XI17_QIN_SL internal_ck_regs internal_XI17_net19 vdd sg13_lv_pmos w=990.00n l=130.00n m=1
Xinternal_XI17_MP8 internal_XI17_net19 internal_XI17_QI_MS vdd vdd sg13_lv_pmos w=990.00n l=130.00n m=1
Xinternal_XI16_MN0 internal_col_re internal_XI16_QIN_SL gnd gnd sg13_lv_nmos w=980.00n l=130.00n m=1
Xinternal_XI16_MN10 internal_XI16_QIN_SL internal_XI16_CNN internal_XI16_net21 gnd sg13_lv_nmos w=850.00n l=130.00n m=1
Xinternal_XI16_MN11 internal_XI16_net21 internal_XI16_QI_MS gnd gnd sg13_lv_nmos w=850.00n l=130.00n m=1
Xinternal_XI16_MN7 internal_XI16_net30 internal_XI16_QI_MS gnd gnd sg13_lv_nmos w=480.00n l=130.00n m=1
Xinternal_XI16_MN6 internal_XI16_QIN_MS internal_XI16_CNN internal_XI16_net30 gnd sg13_lv_nmos w=480.00n l=130.00n m=1
Xinternal_XI16_MN3 internal_XI16_QI_MS internal_XI16_QIN_MS gnd gnd sg13_lv_nmos w=480.00n l=130.00n m=1
Xinternal_XI16_MN12 internal_XI16_CNN internal_ck_regs gnd gnd sg13_lv_nmos w=495.000n l=130.00n m=1
Xinternal_XI16_MN9 internal_XI16_net37 internal_re gnd gnd sg13_lv_nmos w=870.00n l=130.00n m=1
Xinternal_XI16_MN8 internal_XI16_QIN_MS internal_ck_regs internal_XI16_net37 gnd sg13_lv_nmos w=870.00n l=130.00n m=1
Xinternal_XI16_MN5 internal_XI16_QIN_SL internal_ck_regs internal_XI16_net25 gnd sg13_lv_nmos w=480.00n l=130.00n m=1
Xinternal_XI16_MN4 internal_XI16_net25 internal_XI16_QI_SL gnd gnd sg13_lv_nmos w=480.00n l=130.00n m=1
Xinternal_XI16_MN2 internal_XI16_QI_SL internal_XI16_QIN_SL gnd gnd sg13_lv_nmos w=480.00n l=130.00n m=1
Xinternal_XI16_MP0 internal_col_re internal_XI16_QIN_SL vdd vdd sg13_lv_pmos w=1.62u l=130.00n m=1
Xinternal_XI16_MP6 internal_XI16_QI_MS internal_XI16_QIN_MS vdd vdd sg13_lv_pmos w=480.00n l=130.00n m=1
Xinternal_XI16_MP3 internal_XI16_QIN_SL internal_XI16_CNN internal_XI16_net27 vdd sg13_lv_pmos w=480.00n l=130.00n m=1
Xinternal_XI16_MP2 internal_XI16_net27 internal_XI16_QI_SL vdd vdd sg13_lv_pmos w=480.00n l=130.00n m=1
Xinternal_XI16_MP10 internal_XI16_net36 internal_re vdd vdd sg13_lv_pmos w=975.000n l=130.00n m=1
Xinternal_XI16_MP11 internal_XI16_QIN_MS internal_XI16_CNN internal_XI16_net36 vdd sg13_lv_pmos w=975.000n l=130.00n m=1
Xinternal_XI16_MP4 internal_XI16_net32 internal_XI16_QI_MS vdd vdd sg13_lv_pmos w=480.00n l=130.00n m=1
Xinternal_XI16_MP5 internal_XI16_QIN_MS internal_ck_regs internal_XI16_net32 vdd sg13_lv_pmos w=480.00n l=130.00n m=1
Xinternal_XI16_MP7 internal_XI16_QI_SL internal_XI16_QIN_SL vdd vdd sg13_lv_pmos w=480.00n l=130.00n m=1
Xinternal_XI16_MP12 internal_XI16_CNN internal_ck_regs vdd vdd sg13_lv_pmos w=480.00n l=130.00n m=1
Xinternal_XI16_MP9 internal_XI16_QIN_SL internal_ck_regs internal_XI16_net19 vdd sg13_lv_pmos w=990.00n l=130.00n m=1
Xinternal_XI16_MP8 internal_XI16_net19 internal_XI16_QI_MS vdd vdd sg13_lv_pmos w=990.00n l=130.00n m=1
Xinternal_XI18_MN0 internal_net7 internal_XI18_QIN_SL gnd gnd sg13_lv_nmos w=980.00n l=130.00n m=1
Xinternal_XI18_MN10 internal_XI18_QIN_SL internal_XI18_CNN internal_XI18_net21 gnd sg13_lv_nmos w=850.00n l=130.00n m=1
Xinternal_XI18_MN11 internal_XI18_net21 internal_XI18_QI_MS gnd gnd sg13_lv_nmos w=850.00n l=130.00n m=1
Xinternal_XI18_MN7 internal_XI18_net30 internal_XI18_QI_MS gnd gnd sg13_lv_nmos w=480.00n l=130.00n m=1
Xinternal_XI18_MN6 internal_XI18_QIN_MS internal_XI18_CNN internal_XI18_net30 gnd sg13_lv_nmos w=480.00n l=130.00n m=1
Xinternal_XI18_MN3 internal_XI18_QI_MS internal_XI18_QIN_MS gnd gnd sg13_lv_nmos w=480.00n l=130.00n m=1
Xinternal_XI18_MN12 internal_XI18_CNN internal_ck_regs gnd gnd sg13_lv_nmos w=495.000n l=130.00n m=1
Xinternal_XI18_MN9 internal_XI18_net37 internal_cs gnd gnd sg13_lv_nmos w=870.00n l=130.00n m=1
Xinternal_XI18_MN8 internal_XI18_QIN_MS internal_ck_regs internal_XI18_net37 gnd sg13_lv_nmos w=870.00n l=130.00n m=1
Xinternal_XI18_MN5 internal_XI18_QIN_SL internal_ck_regs internal_XI18_net25 gnd sg13_lv_nmos w=480.00n l=130.00n m=1
Xinternal_XI18_MN4 internal_XI18_net25 internal_XI18_QI_SL gnd gnd sg13_lv_nmos w=480.00n l=130.00n m=1
Xinternal_XI18_MN2 internal_XI18_QI_SL internal_XI18_QIN_SL gnd gnd sg13_lv_nmos w=480.00n l=130.00n m=1
Xinternal_XI18_MP0 internal_net7 internal_XI18_QIN_SL vdd vdd sg13_lv_pmos w=1.62u l=130.00n m=1
Xinternal_XI18_MP6 internal_XI18_QI_MS internal_XI18_QIN_MS vdd vdd sg13_lv_pmos w=480.00n l=130.00n m=1
Xinternal_XI18_MP3 internal_XI18_QIN_SL internal_XI18_CNN internal_XI18_net27 vdd sg13_lv_pmos w=480.00n l=130.00n m=1
Xinternal_XI18_MP2 internal_XI18_net27 internal_XI18_QI_SL vdd vdd sg13_lv_pmos w=480.00n l=130.00n m=1
Xinternal_XI18_MP10 internal_XI18_net36 internal_cs vdd vdd sg13_lv_pmos w=975.000n l=130.00n m=1
Xinternal_XI18_MP11 internal_XI18_QIN_MS internal_XI18_CNN internal_XI18_net36 vdd sg13_lv_pmos w=975.000n l=130.00n m=1
Xinternal_XI18_MP4 internal_XI18_net32 internal_XI18_QI_MS vdd vdd sg13_lv_pmos w=480.00n l=130.00n m=1
Xinternal_XI18_MP5 internal_XI18_QIN_MS internal_ck_regs internal_XI18_net32 vdd sg13_lv_pmos w=480.00n l=130.00n m=1
Xinternal_XI18_MP7 internal_XI18_QI_SL internal_XI18_QIN_SL vdd vdd sg13_lv_pmos w=480.00n l=130.00n m=1
Xinternal_XI18_MP12 internal_XI18_CNN internal_ck_regs vdd vdd sg13_lv_pmos w=480.00n l=130.00n m=1
Xinternal_XI18_MP9 internal_XI18_QIN_SL internal_ck_regs internal_XI18_net19 vdd sg13_lv_pmos w=990.00n l=130.00n m=1
Xinternal_XI18_MP8 internal_XI18_net19 internal_XI18_QI_MS vdd vdd sg13_lv_pmos w=990.00n l=130.00n m=1
Xinternal_XI71_MN0 pulse internal_XI71_QIN_SL gnd gnd sg13_lv_nmos w=980.00n l=130.00n m=1
Xinternal_XI71_MN10 internal_XI71_QIN_SL internal_XI71_CNN internal_XI71_net21 gnd sg13_lv_nmos w=850.00n l=130.00n m=1
Xinternal_XI71_MN11 internal_XI71_net21 internal_XI71_QI_MS gnd gnd sg13_lv_nmos w=850.00n l=130.00n m=1
Xinternal_XI71_MN7 internal_XI71_net30 internal_XI71_QI_MS gnd gnd sg13_lv_nmos w=480.00n l=130.00n m=1
Xinternal_XI71_MN6 internal_XI71_QIN_MS internal_XI71_CNN internal_XI71_net30 gnd sg13_lv_nmos w=480.00n l=130.00n m=1
Xinternal_XI71_MN3 internal_XI71_QI_MS internal_XI71_QIN_MS gnd gnd sg13_lv_nmos w=480.00n l=130.00n m=1
Xinternal_XI71_MN12 internal_XI71_CNN aclk_n gnd gnd sg13_lv_nmos w=495.000n l=130.00n m=1
Xinternal_XI71_MN9 internal_XI71_net37 internal_net012 gnd gnd sg13_lv_nmos w=870.00n l=130.00n m=1
Xinternal_XI71_MN8 internal_XI71_QIN_MS aclk_n internal_XI71_net37 gnd sg13_lv_nmos w=870.00n l=130.00n m=1
Xinternal_XI71_MN5 internal_XI71_QIN_SL aclk_n internal_XI71_net25 gnd sg13_lv_nmos w=480.00n l=130.00n m=1
Xinternal_XI71_MN4 internal_XI71_net25 internal_XI71_QI_SL gnd gnd sg13_lv_nmos w=480.00n l=130.00n m=1
Xinternal_XI71_MN2 internal_XI71_QI_SL internal_XI71_QIN_SL gnd gnd sg13_lv_nmos w=480.00n l=130.00n m=1
Xinternal_XI71_MP0 pulse internal_XI71_QIN_SL vdd vdd sg13_lv_pmos w=1.62u l=130.00n m=1
Xinternal_XI71_MP6 internal_XI71_QI_MS internal_XI71_QIN_MS vdd vdd sg13_lv_pmos w=480.00n l=130.00n m=1
Xinternal_XI71_MP3 internal_XI71_QIN_SL internal_XI71_CNN internal_XI71_net27 vdd sg13_lv_pmos w=480.00n l=130.00n m=1
Xinternal_XI71_MP2 internal_XI71_net27 internal_XI71_QI_SL vdd vdd sg13_lv_pmos w=480.00n l=130.00n m=1
Xinternal_XI71_MP10 internal_XI71_net36 internal_net012 vdd vdd sg13_lv_pmos w=975.000n l=130.00n m=1
Xinternal_XI71_MP11 internal_XI71_QIN_MS internal_XI71_CNN internal_XI71_net36 vdd sg13_lv_pmos w=975.000n l=130.00n m=1
Xinternal_XI71_MP4 internal_XI71_net32 internal_XI71_QI_MS vdd vdd sg13_lv_pmos w=480.00n l=130.00n m=1
Xinternal_XI71_MP5 internal_XI71_QIN_MS aclk_n internal_XI71_net32 vdd sg13_lv_pmos w=480.00n l=130.00n m=1
Xinternal_XI71_MP7 internal_XI71_QI_SL internal_XI71_QIN_SL vdd vdd sg13_lv_pmos w=480.00n l=130.00n m=1
Xinternal_XI71_MP12 internal_XI71_CNN aclk_n vdd vdd sg13_lv_pmos w=480.00n l=130.00n m=1
Xinternal_XI71_MP9 internal_XI71_QIN_SL aclk_n internal_XI71_net19 vdd sg13_lv_pmos w=990.00n l=130.00n m=1
Xinternal_XI71_MP8 internal_XI71_net19 internal_XI71_QI_MS vdd vdd sg13_lv_pmos w=990.00n l=130.00n m=1
Xinternal_XI77_MN0 internal_net016 internal_net9 internal_XI77_net6 gnd sg13_lv_nmos w=980.00n l=130.00n m=1
Xinternal_XI77_MN1 internal_XI77_net6 internal_col_we gnd gnd sg13_lv_nmos w=980.00n l=130.00n m=1
Xinternal_XI77_MP1 internal_net016 internal_net9 vdd vdd sg13_lv_pmos w=1.62u l=130.00n m=1
Xinternal_XI77_MP0 internal_net016 internal_col_we vdd vdd sg13_lv_pmos w=1.62u l=130.00n m=1
Xinternal_XI76_MN0 internal_net018 internal_net9 internal_XI76_net6 gnd sg13_lv_nmos w=980.00n l=130.00n m=1
Xinternal_XI76_MN1 internal_XI76_net6 internal_col_re gnd gnd sg13_lv_nmos w=980.00n l=130.00n m=1
Xinternal_XI76_MP1 internal_net018 internal_net9 vdd vdd sg13_lv_pmos w=1.62u l=130.00n m=1
Xinternal_XI76_MP0 internal_net018 internal_col_re vdd vdd sg13_lv_pmos w=1.62u l=130.00n m=1
Xinternal_XI15_MN1 internal_XI15_net08 internal_XI15_QIN gnd gnd sg13_lv_nmos w=480.00n l=130.00n m=1
Xinternal_XI15_MN2 internal_XI15_net019 internal_XI15_net08 gnd gnd sg13_lv_nmos w=480.00n l=130.00n m=1
Xinternal_XI15_MN3 internal_XI15_QIN internal_ck_dly internal_XI15_net019 gnd sg13_lv_nmos w=480.00n l=130.00n m=1
Xinternal_XI15_MN6 internal_aclk internal_XI15_net015 gnd gnd sg13_lv_nmos w=1.41u l=130.00n m=1
Xinternal_XI15_MN5 internal_XI15_net015 internal_XI15_net08 internal_XI15_net018 gnd sg13_lv_nmos w=980.00n l=130.00n m=1
Xinternal_XI15_MN8 internal_XI15_QIN internal_XI15_CPN internal_XI15_net023 gnd sg13_lv_nmos w=870.00n l=130.00n m=1
Xinternal_XI15_MN7 internal_XI15_net023 internal_WEorREandCS gnd gnd sg13_lv_nmos w=870.00n l=130.00n m=1
Xinternal_XI15_MN4 internal_XI15_net018 internal_ck_dly gnd gnd sg13_lv_nmos w=980.00n l=130.00n m=1
Xinternal_XI15_MN0 internal_XI15_CPN internal_ck_dly gnd gnd sg13_lv_nmos w=500.0n l=130.00n m=1
Xinternal_XI15_MP3 internal_XI15_net08 internal_XI15_QIN vdd vdd sg13_lv_pmos w=480.00n l=130.00n m=1
Xinternal_XI15_MP2 internal_XI15_QIN internal_XI15_CPN internal_XI15_net017 vdd sg13_lv_pmos w=480.00n l=130.00n m=1
Xinternal_XI15_MP1 internal_XI15_net017 internal_XI15_net08 vdd vdd sg13_lv_pmos w=480.00n l=130.00n m=1
Xinternal_XI15_MP0 internal_XI15_CPN internal_ck_dly vdd vdd sg13_lv_pmos w=500.0n l=130.00n m=1
Xinternal_XI15_MP8 internal_XI15_QIN internal_ck_dly internal_XI15_net024 vdd sg13_lv_pmos w=975.000n l=130.00n m=1
Xinternal_XI15_MP7 internal_XI15_net024 internal_WEorREandCS vdd vdd sg13_lv_pmos w=975.000n l=130.00n m=1
Xinternal_XI15_MP4 internal_XI15_net015 internal_ck_dly vdd vdd sg13_lv_pmos w=1.27u l=130.00n m=1
Xinternal_XI15_MP6 internal_aclk internal_XI15_net015 vdd vdd sg13_lv_pmos w=3.24u l=130.00n m=1
Xinternal_XI15_MP5 internal_XI15_net015 internal_XI15_net08 vdd vdd sg13_lv_pmos w=1.27u l=130.00n m=1
Xinternal_XI14_MN1 internal_XI14_net08 internal_XI14_QIN gnd gnd sg13_lv_nmos w=480.00n l=130.00n m=1
Xinternal_XI14_MN2 internal_XI14_net019 internal_XI14_net08 gnd gnd sg13_lv_nmos w=480.00n l=130.00n m=1
Xinternal_XI14_MN3 internal_XI14_QIN internal_ck internal_XI14_net019 gnd sg13_lv_nmos w=480.00n l=130.00n m=1
Xinternal_XI14_MN6 dclk internal_XI14_net015 gnd gnd sg13_lv_nmos w=1.41u l=130.00n m=1
Xinternal_XI14_MN5 internal_XI14_net015 internal_XI14_net08 internal_XI14_net018 gnd sg13_lv_nmos w=980.00n l=130.00n m=1
Xinternal_XI14_MN8 internal_XI14_QIN internal_XI14_CPN internal_XI14_net023 gnd sg13_lv_nmos w=870.00n l=130.00n m=1
Xinternal_XI14_MN7 internal_XI14_net023 internal_WEandCS gnd gnd sg13_lv_nmos w=870.00n l=130.00n m=1
Xinternal_XI14_MN4 internal_XI14_net018 internal_ck gnd gnd sg13_lv_nmos w=980.00n l=130.00n m=1
Xinternal_XI14_MN0 internal_XI14_CPN internal_ck gnd gnd sg13_lv_nmos w=500.0n l=130.00n m=1
Xinternal_XI14_MP3 internal_XI14_net08 internal_XI14_QIN vdd vdd sg13_lv_pmos w=480.00n l=130.00n m=1
Xinternal_XI14_MP2 internal_XI14_QIN internal_XI14_CPN internal_XI14_net017 vdd sg13_lv_pmos w=480.00n l=130.00n m=1
Xinternal_XI14_MP1 internal_XI14_net017 internal_XI14_net08 vdd vdd sg13_lv_pmos w=480.00n l=130.00n m=1
Xinternal_XI14_MP0 internal_XI14_CPN internal_ck vdd vdd sg13_lv_pmos w=500.0n l=130.00n m=1
Xinternal_XI14_MP8 internal_XI14_QIN internal_ck internal_XI14_net024 vdd sg13_lv_pmos w=975.000n l=130.00n m=1
Xinternal_XI14_MP7 internal_XI14_net024 internal_WEandCS vdd vdd sg13_lv_pmos w=975.000n l=130.00n m=1
Xinternal_XI14_MP4 internal_XI14_net015 internal_ck vdd vdd sg13_lv_pmos w=1.27u l=130.00n m=1
Xinternal_XI14_MP6 dclk internal_XI14_net015 vdd vdd sg13_lv_pmos w=3.24u l=130.00n m=1
Xinternal_XI14_MP5 internal_XI14_net015 internal_XI14_net08 vdd vdd sg13_lv_pmos w=1.27u l=130.00n m=1
Xinternal_XI60_MP0 internal_XI60_net4 internal_net7 vdd vdd sg13_lv_pmos w=3.24u l=130.00n m=1
Xinternal_XI60_MP1 row_cs internal_XI60_net4 vdd vdd sg13_lv_pmos w=6.48u l=130.00n m=1
Xinternal_XI60_MN1 row_cs internal_XI60_net4 gnd gnd sg13_lv_nmos w=2.82u l=130.00n m=1
Xinternal_XI60_MN0 internal_XI60_net4 internal_net7 gnd gnd sg13_lv_nmos w=1.41u l=130.00n m=1
Xinternal_XI73_MN0 internal_net012 pulse gnd gnd sg13_lv_nmos w=705.000n l=130.00n m=1
Xinternal_XI73_MP0 internal_net012 pulse vdd vdd sg13_lv_pmos w=1.62u l=130.00n m=1
Xinternal_XI8_MN0 internal_net8 internal_net9 gnd gnd sg13_lv_nmos w=705.000n l=130.00n m=1
Xinternal_XI8_MP0 internal_net8 internal_net9 vdd vdd sg13_lv_pmos w=1.62u l=130.00n m=1
Xinternal_XI64_MN2 internal_XI64_net4 internal_ck internal_XI64_net9 gnd sg13_lv_nmos w=320.00n l=200.0n m=1
Xinternal_XI64_MN0 internal_ck_dly internal_XI64_net4 gnd gnd sg13_lv_nmos w=705.000n l=130.00n m=1
Xinternal_XI64_MN1 internal_XI64_net9 internal_ck gnd gnd sg13_lv_nmos w=320.00n l=200.0n m=1
Xinternal_XI64_MP2 internal_XI64_net4 internal_ck internal_XI64_net10 vdd sg13_lv_pmos w=1.2u l=200.0n m=1
Xinternal_XI64_MP1 internal_XI64_net10 internal_ck vdd vdd sg13_lv_pmos w=1.2u l=200.0n m=1
Xinternal_XI64_MP0 internal_ck_dly internal_XI64_net4 vdd vdd sg13_lv_pmos w=1.62u l=130.00n m=1
Xinternal_XI86_MP6 internal_cs internal_XI86_net010 vdd vdd sg13_lv_pmos w=1.62u l=130.00n m=1
Xinternal_XI86_MP4 internal_XI86_SN bist_en vdd vdd sg13_lv_pmos w=645.000n l=130.00n m=1
Xinternal_XI86_MP3 internal_XI86_net010 internal_XI86_SN internal_XI86_net12 vdd sg13_lv_pmos w=985.000n l=130.00n m=1
Xinternal_XI86_MP2 internal_XI86_net12 bist_cs vdd vdd sg13_lv_pmos w=985.000n l=130.00n m=1
Xinternal_XI86_MP1 internal_XI86_net010 bist_en internal_XI86_net17 vdd sg13_lv_pmos w=985.000n l=130.00n m=1
Xinternal_XI86_MP0 internal_XI86_net17 cs vdd vdd sg13_lv_pmos w=985.000n l=130.00n m=1
Xinternal_XI86_MN6 internal_cs internal_XI86_net010 gnd gnd sg13_lv_nmos w=705.000n l=130.00n m=1
Xinternal_XI86_MN5 internal_XI86_SN bist_en gnd gnd sg13_lv_nmos w=560.00n l=130.00n m=1
Xinternal_XI86_MN3 internal_XI86_net13 bist_cs gnd gnd sg13_lv_nmos w=560.00n l=130.00n m=1
Xinternal_XI86_MN2 internal_XI86_net010 bist_en internal_XI86_net13 gnd sg13_lv_nmos w=560.00n l=130.00n m=1
Xinternal_XI86_MN1 internal_XI86_net15 cs gnd gnd sg13_lv_nmos w=560.00n l=130.00n m=1
Xinternal_XI86_MN0 internal_XI86_net010 internal_XI86_SN internal_XI86_net15 gnd sg13_lv_nmos w=560.00n l=130.00n m=1
Xinternal_XI87_MP6 internal_ck internal_XI87_net010 vdd vdd sg13_lv_pmos w=1.62u l=130.00n m=1
Xinternal_XI87_MP4 internal_XI87_SN bist_en vdd vdd sg13_lv_pmos w=645.000n l=130.00n m=1
Xinternal_XI87_MP3 internal_XI87_net010 internal_XI87_SN internal_XI87_net12 vdd sg13_lv_pmos w=985.000n l=130.00n m=1
Xinternal_XI87_MP2 internal_XI87_net12 bist_clk vdd vdd sg13_lv_pmos w=985.000n l=130.00n m=1
Xinternal_XI87_MP1 internal_XI87_net010 bist_en internal_XI87_net17 vdd sg13_lv_pmos w=985.000n l=130.00n m=1
Xinternal_XI87_MP0 internal_XI87_net17 clk vdd vdd sg13_lv_pmos w=985.000n l=130.00n m=1
Xinternal_XI87_MN6 internal_ck internal_XI87_net010 gnd gnd sg13_lv_nmos w=705.000n l=130.00n m=1
Xinternal_XI87_MN5 internal_XI87_SN bist_en gnd gnd sg13_lv_nmos w=560.00n l=130.00n m=1
Xinternal_XI87_MN3 internal_XI87_net13 bist_clk gnd gnd sg13_lv_nmos w=560.00n l=130.00n m=1
Xinternal_XI87_MN2 internal_XI87_net010 bist_en internal_XI87_net13 gnd sg13_lv_nmos w=560.00n l=130.00n m=1
Xinternal_XI87_MN1 internal_XI87_net15 clk gnd gnd sg13_lv_nmos w=560.00n l=130.00n m=1
Xinternal_XI87_MN0 internal_XI87_net010 internal_XI87_SN internal_XI87_net15 gnd sg13_lv_nmos w=560.00n l=130.00n m=1
Xinternal_XI85_MP6 internal_we internal_XI85_net010 vdd vdd sg13_lv_pmos w=1.62u l=130.00n m=1
Xinternal_XI85_MP4 internal_XI85_SN bist_en vdd vdd sg13_lv_pmos w=645.000n l=130.00n m=1
Xinternal_XI85_MP3 internal_XI85_net010 internal_XI85_SN internal_XI85_net12 vdd sg13_lv_pmos w=985.000n l=130.00n m=1
Xinternal_XI85_MP2 internal_XI85_net12 bist_we vdd vdd sg13_lv_pmos w=985.000n l=130.00n m=1
Xinternal_XI85_MP1 internal_XI85_net010 bist_en internal_XI85_net17 vdd sg13_lv_pmos w=985.000n l=130.00n m=1
Xinternal_XI85_MP0 internal_XI85_net17 we vdd vdd sg13_lv_pmos w=985.000n l=130.00n m=1
Xinternal_XI85_MN6 internal_we internal_XI85_net010 gnd gnd sg13_lv_nmos w=705.000n l=130.00n m=1
Xinternal_XI85_MN5 internal_XI85_SN bist_en gnd gnd sg13_lv_nmos w=560.00n l=130.00n m=1
Xinternal_XI85_MN3 internal_XI85_net13 bist_we gnd gnd sg13_lv_nmos w=560.00n l=130.00n m=1
Xinternal_XI85_MN2 internal_XI85_net010 bist_en internal_XI85_net13 gnd sg13_lv_nmos w=560.00n l=130.00n m=1
Xinternal_XI85_MN1 internal_XI85_net15 we gnd gnd sg13_lv_nmos w=560.00n l=130.00n m=1
Xinternal_XI85_MN0 internal_XI85_net010 internal_XI85_SN internal_XI85_net15 gnd sg13_lv_nmos w=560.00n l=130.00n m=1
Xinternal_XI84_MP6 internal_re internal_XI84_net010 vdd vdd sg13_lv_pmos w=1.62u l=130.00n m=1
Xinternal_XI84_MP4 internal_XI84_SN bist_en vdd vdd sg13_lv_pmos w=645.000n l=130.00n m=1
Xinternal_XI84_MP3 internal_XI84_net010 internal_XI84_SN internal_XI84_net12 vdd sg13_lv_pmos w=985.000n l=130.00n m=1
Xinternal_XI84_MP2 internal_XI84_net12 bist_re vdd vdd sg13_lv_pmos w=985.000n l=130.00n m=1
Xinternal_XI84_MP1 internal_XI84_net010 bist_en internal_XI84_net17 vdd sg13_lv_pmos w=985.000n l=130.00n m=1
Xinternal_XI84_MP0 internal_XI84_net17 re vdd vdd sg13_lv_pmos w=985.000n l=130.00n m=1
Xinternal_XI84_MN6 internal_re internal_XI84_net010 gnd gnd sg13_lv_nmos w=705.000n l=130.00n m=1
Xinternal_XI84_MN5 internal_XI84_SN bist_en gnd gnd sg13_lv_nmos w=560.00n l=130.00n m=1
Xinternal_XI84_MN3 internal_XI84_net13 bist_re gnd gnd sg13_lv_nmos w=560.00n l=130.00n m=1
Xinternal_XI84_MN2 internal_XI84_net010 bist_en internal_XI84_net13 gnd sg13_lv_nmos w=560.00n l=130.00n m=1
Xinternal_XI84_MN1 internal_XI84_net15 re gnd gnd sg13_lv_nmos w=560.00n l=130.00n m=1
Xinternal_XI84_MN0 internal_XI84_net010 internal_XI84_SN internal_XI84_net15 gnd sg13_lv_nmos w=560.00n l=130.00n m=1
Xinternal_XI22_MN3 internal_WEandCS internal_XI22_net6 gnd gnd sg13_lv_nmos w=980.00n l=130.00n m=1
Xinternal_XI22_MN4 internal_XI22_net9 internal_cs gnd gnd sg13_lv_nmos w=500.0n l=130.00n m=1
Xinternal_XI22_MN6 internal_XI22_net6 internal_we internal_XI22_net9 gnd sg13_lv_nmos w=500.0n l=130.00n m=1
Xinternal_XI22_MP2 internal_WEandCS internal_XI22_net6 vdd vdd sg13_lv_pmos w=1.62u l=130.00n m=1
Xinternal_XI22_MP0 internal_XI22_net6 internal_cs vdd vdd sg13_lv_pmos w=860.00n l=130.00n m=1
Xinternal_XI22_MP1 internal_XI22_net6 internal_we vdd vdd sg13_lv_pmos w=860.00n l=130.00n m=1
Xinternal_XBM_TIEL_MN0 tie_low internal_XBM_TIEL_net2 gnd gnd sg13_lv_nmos w=480.00n l=130.00n m=1
Xinternal_XBM_TIEL_MP0 internal_XBM_TIEL_net2 internal_XBM_TIEL_net2 vdd vdd sg13_lv_pmos w=480.00n l=130.00n m=1
Xinternal_XI48_MN0 internal_ck_regs internal_ck_dly gnd gnd sg13_lv_nmos w=1.41u l=130.00n m=1
Xinternal_XI48_MP0 internal_ck_regs internal_ck_dly vdd vdd sg13_lv_pmos w=3.24u l=130.00n m=1
Xinternal_XI81_MN0 wclk internal_net016 gnd gnd sg13_lv_nmos w=1.41u l=130.00n m=1
Xinternal_XI81_MP0 wclk internal_net016 vdd vdd sg13_lv_pmos w=3.24u l=130.00n m=1
Xinternal_XI80_MN0 rclk internal_net018 gnd gnd sg13_lv_nmos w=1.41u l=130.00n m=1
Xinternal_XI80_MP0 rclk internal_net018 vdd vdd sg13_lv_pmos w=3.24u l=130.00n m=1
Xinternal_XI78_MN0 internal_net020 internal_net8 gnd gnd sg13_lv_nmos w=1.41u l=130.00n m=1
Xinternal_XI78_MP0 internal_net020 internal_net8 vdd vdd sg13_lv_pmos w=3.24u l=130.00n m=1
Xinternal_XI6_MP8 internal_XI6_net012 pulse_h internal_XI6_net7 vdd sg13_lv_pmos w=825.000n l=130.00n m=1
Xinternal_XI6_MP7 internal_XI6_net011 internal_XI6_net3 internal_XI6_net012 vdd sg13_lv_pmos w=825.000n l=130.00n m=1
Xinternal_XI6_MP6 internal_net9 internal_XI6_net012 vdd vdd sg13_lv_pmos w=1.535u l=130.00n m=1
Xinternal_XI6_MP2 internal_XI6_net7 pulse_l vdd vdd sg13_lv_pmos w=825.000n l=130.00n m=1
Xinternal_XI6_MP4 internal_XI6_net011 internal_XI6_net7 vdd vdd sg13_lv_pmos w=825.000n l=130.00n m=1
Xinternal_XI6_MP5 internal_XI6_net3 pulse_h vdd vdd sg13_lv_pmos w=580.00n l=130.00n m=1
Xinternal_XI6_MN7 internal_XI6_net012 pulse_h internal_XI6_net011 gnd sg13_lv_nmos w=555.000n l=130.00n m=1
Xinternal_XI6_MN6 internal_XI6_net7 internal_XI6_net3 internal_XI6_net012 gnd sg13_lv_nmos w=555.000n l=130.00n m=1
Xinternal_XI6_MN5 internal_net9 internal_XI6_net012 gnd gnd sg13_lv_nmos w=775.000n l=130.00n m=1
Xinternal_XI6_MN2 internal_XI6_net7 pulse_l gnd gnd sg13_lv_nmos w=555.000n l=130.00n m=1
Xinternal_XI6_MN4 internal_XI6_net3 pulse_h gnd gnd sg13_lv_nmos w=480.00n l=130.00n m=1
Xinternal_XI6_MN3 internal_XI6_net011 internal_XI6_net7 gnd gnd sg13_lv_nmos w=555.000n l=130.00n m=1
Xinternal_XI79_MN0 eclk internal_net020 gnd gnd sg13_lv_nmos w=2.82u l=130.00n m=1
Xinternal_XI79_MP0 eclk internal_net020 vdd vdd sg13_lv_pmos w=6.48u l=130.00n m=1
Xinternal_XI63_MN0 aclk_n internal_aclk gnd gnd sg13_lv_nmos w=2.82u l=130.00n m=1
Xinternal_XI63_MP0 aclk_n internal_aclk vdd vdd sg13_lv_pmos w=6.48u l=130.00n m=1
Xinternal_XI21_MN2 internal_XI21_net7 internal_cs gnd gnd sg13_lv_nmos w=980.00n l=130.00n m=1
Xinternal_XI21_MN3 internal_WEorREandCS internal_XI21_net17 gnd gnd sg13_lv_nmos w=500.0n l=130.00n m=1
Xinternal_XI21_MN1 internal_XI21_net17 internal_we internal_XI21_net7 gnd sg13_lv_nmos w=980.00n l=130.00n m=1
Xinternal_XI21_MN0 internal_XI21_net17 internal_re internal_XI21_net7 gnd sg13_lv_nmos w=980.00n l=130.00n m=1
Xinternal_XI21_MP0 internal_XI21_net24 internal_re vdd vdd sg13_lv_pmos w=1.62u l=130.00n m=1
Xinternal_XI21_MP3 internal_WEorREandCS internal_XI21_net17 vdd vdd sg13_lv_pmos w=905.000n l=130.00n m=1
Xinternal_XI21_MP1 internal_XI21_net17 internal_we internal_XI21_net24 vdd sg13_lv_pmos w=1.62u l=130.00n m=1
Xinternal_XI21_MP2 internal_XI21_net17 internal_cs vdd vdd sg13_lv_pmos w=905.000n l=130.00n m=1
.ends ihp_controller
