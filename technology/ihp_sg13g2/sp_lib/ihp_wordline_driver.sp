* ------------------------------------------------------
*
*		Copyright 2025 IHP PDK Authors
*
*		Licensed under the Apache License, Version 2.0 (the "License");
*		you may not use this file except in compliance with the License.
*		You may obtain a copy of the License at
*
*		   https://www.apache.org/licenses/LICENSE-2.0
*
*		Unless required by applicable law or agreed to in writing, software
*		distributed under the License is distributed on an "AS IS" BASIS,
*		WITHOUT WARRANTIES OR CONDITIONS OF ANY KIND, either express or implied.
*		See the License for the specific language governing permissions and
*		limitations under the License.
*
*		Generated on Thu Jul 30 11:38:32 2026
*
* ------------------------------------------------------
* Flattened from RM_IHPSG13_64x16_c2_1P_WLDRV16X4; unchanged W/L/m.
.subckt ihp_wordline_driver decode_15 decode_14 decode_13 decode_12 decode_11 decode_10 decode_9 decode_8 decode_7 decode_6 decode_5 decode_4 decode_3 decode_2 decode_1 decode_0 wl_15 wl_14 wl_13 wl_12 wl_11 wl_10 wl_9 wl_8 wl_7 wl_6 wl_5 wl_4 wl_3 wl_2 wl_1 wl_0 vdd gnd
XXBUF<15>_MN1 wl_15 XBUF<15>_net6 gnd gnd sg13_lv_nmos w=705.000n l=130.00n m=1
XXBUF<15>_MN0 XBUF<15>_net6 decode_15 gnd gnd sg13_lv_nmos w=900.0n l=130.00n m=1
XXBUF<15>_MP1 wl_15 XBUF<15>_net6 vdd vdd sg13_lv_pmos w=3.24u l=130.00n m=1
XXBUF<15>_MP0 XBUF<15>_net6 decode_15 vdd vdd sg13_lv_pmos w=900.0n l=130.00n m=1
XXBUF<14>_MN1 wl_14 XBUF<14>_net6 gnd gnd sg13_lv_nmos w=705.000n l=130.00n m=1
XXBUF<14>_MN0 XBUF<14>_net6 decode_14 gnd gnd sg13_lv_nmos w=900.0n l=130.00n m=1
XXBUF<14>_MP1 wl_14 XBUF<14>_net6 vdd vdd sg13_lv_pmos w=3.24u l=130.00n m=1
XXBUF<14>_MP0 XBUF<14>_net6 decode_14 vdd vdd sg13_lv_pmos w=900.0n l=130.00n m=1
XXBUF<13>_MN1 wl_13 XBUF<13>_net6 gnd gnd sg13_lv_nmos w=705.000n l=130.00n m=1
XXBUF<13>_MN0 XBUF<13>_net6 decode_13 gnd gnd sg13_lv_nmos w=900.0n l=130.00n m=1
XXBUF<13>_MP1 wl_13 XBUF<13>_net6 vdd vdd sg13_lv_pmos w=3.24u l=130.00n m=1
XXBUF<13>_MP0 XBUF<13>_net6 decode_13 vdd vdd sg13_lv_pmos w=900.0n l=130.00n m=1
XXBUF<12>_MN1 wl_12 XBUF<12>_net6 gnd gnd sg13_lv_nmos w=705.000n l=130.00n m=1
XXBUF<12>_MN0 XBUF<12>_net6 decode_12 gnd gnd sg13_lv_nmos w=900.0n l=130.00n m=1
XXBUF<12>_MP1 wl_12 XBUF<12>_net6 vdd vdd sg13_lv_pmos w=3.24u l=130.00n m=1
XXBUF<12>_MP0 XBUF<12>_net6 decode_12 vdd vdd sg13_lv_pmos w=900.0n l=130.00n m=1
XXBUF<11>_MN1 wl_11 XBUF<11>_net6 gnd gnd sg13_lv_nmos w=705.000n l=130.00n m=1
XXBUF<11>_MN0 XBUF<11>_net6 decode_11 gnd gnd sg13_lv_nmos w=900.0n l=130.00n m=1
XXBUF<11>_MP1 wl_11 XBUF<11>_net6 vdd vdd sg13_lv_pmos w=3.24u l=130.00n m=1
XXBUF<11>_MP0 XBUF<11>_net6 decode_11 vdd vdd sg13_lv_pmos w=900.0n l=130.00n m=1
XXBUF<10>_MN1 wl_10 XBUF<10>_net6 gnd gnd sg13_lv_nmos w=705.000n l=130.00n m=1
XXBUF<10>_MN0 XBUF<10>_net6 decode_10 gnd gnd sg13_lv_nmos w=900.0n l=130.00n m=1
XXBUF<10>_MP1 wl_10 XBUF<10>_net6 vdd vdd sg13_lv_pmos w=3.24u l=130.00n m=1
XXBUF<10>_MP0 XBUF<10>_net6 decode_10 vdd vdd sg13_lv_pmos w=900.0n l=130.00n m=1
XXBUF<9>_MN1 wl_9 XBUF<9>_net6 gnd gnd sg13_lv_nmos w=705.000n l=130.00n m=1
XXBUF<9>_MN0 XBUF<9>_net6 decode_9 gnd gnd sg13_lv_nmos w=900.0n l=130.00n m=1
XXBUF<9>_MP1 wl_9 XBUF<9>_net6 vdd vdd sg13_lv_pmos w=3.24u l=130.00n m=1
XXBUF<9>_MP0 XBUF<9>_net6 decode_9 vdd vdd sg13_lv_pmos w=900.0n l=130.00n m=1
XXBUF<8>_MN1 wl_8 XBUF<8>_net6 gnd gnd sg13_lv_nmos w=705.000n l=130.00n m=1
XXBUF<8>_MN0 XBUF<8>_net6 decode_8 gnd gnd sg13_lv_nmos w=900.0n l=130.00n m=1
XXBUF<8>_MP1 wl_8 XBUF<8>_net6 vdd vdd sg13_lv_pmos w=3.24u l=130.00n m=1
XXBUF<8>_MP0 XBUF<8>_net6 decode_8 vdd vdd sg13_lv_pmos w=900.0n l=130.00n m=1
XXBUF<7>_MN1 wl_7 XBUF<7>_net6 gnd gnd sg13_lv_nmos w=705.000n l=130.00n m=1
XXBUF<7>_MN0 XBUF<7>_net6 decode_7 gnd gnd sg13_lv_nmos w=900.0n l=130.00n m=1
XXBUF<7>_MP1 wl_7 XBUF<7>_net6 vdd vdd sg13_lv_pmos w=3.24u l=130.00n m=1
XXBUF<7>_MP0 XBUF<7>_net6 decode_7 vdd vdd sg13_lv_pmos w=900.0n l=130.00n m=1
XXBUF<6>_MN1 wl_6 XBUF<6>_net6 gnd gnd sg13_lv_nmos w=705.000n l=130.00n m=1
XXBUF<6>_MN0 XBUF<6>_net6 decode_6 gnd gnd sg13_lv_nmos w=900.0n l=130.00n m=1
XXBUF<6>_MP1 wl_6 XBUF<6>_net6 vdd vdd sg13_lv_pmos w=3.24u l=130.00n m=1
XXBUF<6>_MP0 XBUF<6>_net6 decode_6 vdd vdd sg13_lv_pmos w=900.0n l=130.00n m=1
XXBUF<5>_MN1 wl_5 XBUF<5>_net6 gnd gnd sg13_lv_nmos w=705.000n l=130.00n m=1
XXBUF<5>_MN0 XBUF<5>_net6 decode_5 gnd gnd sg13_lv_nmos w=900.0n l=130.00n m=1
XXBUF<5>_MP1 wl_5 XBUF<5>_net6 vdd vdd sg13_lv_pmos w=3.24u l=130.00n m=1
XXBUF<5>_MP0 XBUF<5>_net6 decode_5 vdd vdd sg13_lv_pmos w=900.0n l=130.00n m=1
XXBUF<4>_MN1 wl_4 XBUF<4>_net6 gnd gnd sg13_lv_nmos w=705.000n l=130.00n m=1
XXBUF<4>_MN0 XBUF<4>_net6 decode_4 gnd gnd sg13_lv_nmos w=900.0n l=130.00n m=1
XXBUF<4>_MP1 wl_4 XBUF<4>_net6 vdd vdd sg13_lv_pmos w=3.24u l=130.00n m=1
XXBUF<4>_MP0 XBUF<4>_net6 decode_4 vdd vdd sg13_lv_pmos w=900.0n l=130.00n m=1
XXBUF<3>_MN1 wl_3 XBUF<3>_net6 gnd gnd sg13_lv_nmos w=705.000n l=130.00n m=1
XXBUF<3>_MN0 XBUF<3>_net6 decode_3 gnd gnd sg13_lv_nmos w=900.0n l=130.00n m=1
XXBUF<3>_MP1 wl_3 XBUF<3>_net6 vdd vdd sg13_lv_pmos w=3.24u l=130.00n m=1
XXBUF<3>_MP0 XBUF<3>_net6 decode_3 vdd vdd sg13_lv_pmos w=900.0n l=130.00n m=1
XXBUF<2>_MN1 wl_2 XBUF<2>_net6 gnd gnd sg13_lv_nmos w=705.000n l=130.00n m=1
XXBUF<2>_MN0 XBUF<2>_net6 decode_2 gnd gnd sg13_lv_nmos w=900.0n l=130.00n m=1
XXBUF<2>_MP1 wl_2 XBUF<2>_net6 vdd vdd sg13_lv_pmos w=3.24u l=130.00n m=1
XXBUF<2>_MP0 XBUF<2>_net6 decode_2 vdd vdd sg13_lv_pmos w=900.0n l=130.00n m=1
XXBUF<1>_MN1 wl_1 XBUF<1>_net6 gnd gnd sg13_lv_nmos w=705.000n l=130.00n m=1
XXBUF<1>_MN0 XBUF<1>_net6 decode_1 gnd gnd sg13_lv_nmos w=900.0n l=130.00n m=1
XXBUF<1>_MP1 wl_1 XBUF<1>_net6 vdd vdd sg13_lv_pmos w=3.24u l=130.00n m=1
XXBUF<1>_MP0 XBUF<1>_net6 decode_1 vdd vdd sg13_lv_pmos w=900.0n l=130.00n m=1
XXBUF<0>_MN1 wl_0 XBUF<0>_net6 gnd gnd sg13_lv_nmos w=705.000n l=130.00n m=1
XXBUF<0>_MN0 XBUF<0>_net6 decode_0 gnd gnd sg13_lv_nmos w=900.0n l=130.00n m=1
XXBUF<0>_MP1 wl_0 XBUF<0>_net6 vdd vdd sg13_lv_pmos w=3.24u l=130.00n m=1
XXBUF<0>_MP0 XBUF<0>_net6 decode_0 vdd vdd sg13_lv_pmos w=900.0n l=130.00n m=1
.ends ihp_wordline_driver
