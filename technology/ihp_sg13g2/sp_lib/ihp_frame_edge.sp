* ------------------------------------------------------
*
*		Copyright 2025 IHP PDK Authors
*
*		Licensed under the Apache License, Version 2.0 (the "License");
*		you may not use this file except in compliance with the License.
*		You may obtain a copy of the License at
*
*		   https://www.apache.org/licenses/LICENSE-2.0
*
*		Unless required by applicable law or agreed to in writing, software
*		distributed under the License is distributed on an "AS IS" BASIS,
*		WITHOUT WARRANTIES OR CONDITIONS OF ANY KIND, either express or implied.
*		See the License for the specific language governing permissions and
*		limitations under the License.
*
*		Generated on Thu Jul 30 11:38:32 2026
*
* ------------------------------------------------------
* Unchanged foundry frame geometry; bodies tied by taps.
.subckt ihp_frame_edge wl_0 wl_1 wl_2 wl_3 wl_4 wl_5 wl_6 wl_7 wl_8 wl_9 wl_10 wl_11 wl_12 wl_13 wl_14 wl_15 vdd gnd
Xwl_0 gnd wl_0 gnd gnd sg13_lv_nmos w=300n l=130n m=1
Xdummy_0 gnd floating_0 gnd gnd sg13_lv_nmos w=300n l=130n m=1
Xwl_1 gnd wl_1 gnd gnd sg13_lv_nmos w=300n l=130n m=1
Xdummy_1 gnd floating_1 gnd gnd sg13_lv_nmos w=300n l=130n m=1
Xwl_2 gnd wl_2 gnd gnd sg13_lv_nmos w=300n l=130n m=1
Xdummy_2 gnd floating_2 gnd gnd sg13_lv_nmos w=300n l=130n m=1
Xwl_3 gnd wl_3 gnd gnd sg13_lv_nmos w=300n l=130n m=1
Xdummy_3 gnd floating_3 gnd gnd sg13_lv_nmos w=300n l=130n m=1
Xwl_4 gnd wl_4 gnd gnd sg13_lv_nmos w=300n l=130n m=1
Xdummy_4 gnd floating_4 gnd gnd sg13_lv_nmos w=300n l=130n m=1
Xwl_5 gnd wl_5 gnd gnd sg13_lv_nmos w=300n l=130n m=1
Xdummy_5 gnd floating_5 gnd gnd sg13_lv_nmos w=300n l=130n m=1
Xwl_6 gnd wl_6 gnd gnd sg13_lv_nmos w=300n l=130n m=1
Xdummy_6 gnd floating_6 gnd gnd sg13_lv_nmos w=300n l=130n m=1
Xwl_7 gnd wl_7 gnd gnd sg13_lv_nmos w=300n l=130n m=1
Xdummy_7 gnd floating_7 gnd gnd sg13_lv_nmos w=300n l=130n m=1
Xwl_8 gnd wl_8 gnd gnd sg13_lv_nmos w=300n l=130n m=1
Xdummy_8 gnd floating_8 gnd gnd sg13_lv_nmos w=300n l=130n m=1
Xwl_9 gnd wl_9 gnd gnd sg13_lv_nmos w=300n l=130n m=1
Xdummy_9 gnd floating_9 gnd gnd sg13_lv_nmos w=300n l=130n m=1
Xwl_10 gnd wl_10 gnd gnd sg13_lv_nmos w=300n l=130n m=1
Xdummy_10 gnd floating_10 gnd gnd sg13_lv_nmos w=300n l=130n m=1
Xwl_11 gnd wl_11 gnd gnd sg13_lv_nmos w=300n l=130n m=1
Xdummy_11 gnd floating_11 gnd gnd sg13_lv_nmos w=300n l=130n m=1
Xwl_12 gnd wl_12 gnd gnd sg13_lv_nmos w=300n l=130n m=1
Xdummy_12 gnd floating_12 gnd gnd sg13_lv_nmos w=300n l=130n m=1
Xwl_13 gnd wl_13 gnd gnd sg13_lv_nmos w=300n l=130n m=1
Xdummy_13 gnd floating_13 gnd gnd sg13_lv_nmos w=300n l=130n m=1
Xwl_14 gnd wl_14 gnd gnd sg13_lv_nmos w=300n l=130n m=1
Xdummy_14 gnd floating_14 gnd gnd sg13_lv_nmos w=300n l=130n m=1
Xwl_15 gnd wl_15 gnd gnd sg13_lv_nmos w=300n l=130n m=1
Xdummy_15 gnd floating_15 gnd gnd sg13_lv_nmos w=300n l=130n m=1
.ends ihp_frame_edge
