* ------------------------------------------------------
*
*		Copyright 2025 IHP PDK Authors
*
*		Licensed under the Apache License, Version 2.0 (the "License");
*		you may not use this file except in compliance with the License.
*		You may obtain a copy of the License at
*
*		   https://www.apache.org/licenses/LICENSE-2.0
*
*		Unless required by applicable law or agreed to in writing, software
*		distributed under the License is distributed on an "AS IS" BASIS,
*		WITHOUT WARRANTIES OR CONDITIONS OF ANY KIND, either express or implied.
*		See the License for the specific language governing permissions and
*		limitations under the License.
*
*		Generated on Thu Jul 30 11:38:32 2026
*
* ------------------------------------------------------
* Flattened from RM_IHPSG13_64x16_c2_1P_ROWDEC4; unchanged W/L/m.
.subckt ihp_row_decoder addr_3 addr_2 addr_1 addr_0 cs eclk decode_15 decode_14 decode_13 decode_12 decode_11 decode_10 decode_9 decode_8 decode_7 decode_6 decode_5 decode_4 decode_3 decode_2 decode_1 decode_0 vdd gnd
Xinternal_XL2<8>_MN0 internal_XL2<8>_vss_r internal_XL2<8>_vdd_r gnd gnd sg13_lv_nmos w=4.98u l=130.00n m=1
Xinternal_XL2<8>_MP0 internal_XL2<8>_vdd_r internal_XL2<8>_vss_r vdd vdd sg13_lv_pmos w=6.48u l=385.000n m=1
Xinternal_XL2<7>_MN0 internal_XL2<7>_vss_r internal_XL2<7>_vdd_r gnd gnd sg13_lv_nmos w=4.98u l=130.00n m=1
Xinternal_XL2<7>_MP0 internal_XL2<7>_vdd_r internal_XL2<7>_vss_r vdd vdd sg13_lv_pmos w=6.48u l=385.000n m=1
Xinternal_XL2<6>_MN0 internal_XL2<6>_vss_r internal_XL2<6>_vdd_r gnd gnd sg13_lv_nmos w=4.98u l=130.00n m=1
Xinternal_XL2<6>_MP0 internal_XL2<6>_vdd_r internal_XL2<6>_vss_r vdd vdd sg13_lv_pmos w=6.48u l=385.000n m=1
Xinternal_XL2<5>_MN0 internal_XL2<5>_vss_r internal_XL2<5>_vdd_r gnd gnd sg13_lv_nmos w=4.98u l=130.00n m=1
Xinternal_XL2<5>_MP0 internal_XL2<5>_vdd_r internal_XL2<5>_vss_r vdd vdd sg13_lv_pmos w=6.48u l=385.000n m=1
Xinternal_XL2<4>_MN0 internal_XL2<4>_vss_r internal_XL2<4>_vdd_r gnd gnd sg13_lv_nmos w=4.98u l=130.00n m=1
Xinternal_XL2<4>_MP0 internal_XL2<4>_vdd_r internal_XL2<4>_vss_r vdd vdd sg13_lv_pmos w=6.48u l=385.000n m=1
Xinternal_XL2<3>_MN0 internal_XL2<3>_vss_r internal_XL2<3>_vdd_r gnd gnd sg13_lv_nmos w=4.98u l=130.00n m=1
Xinternal_XL2<3>_MP0 internal_XL2<3>_vdd_r internal_XL2<3>_vss_r vdd vdd sg13_lv_pmos w=6.48u l=385.000n m=1
Xinternal_XL2<2>_MN0 internal_XL2<2>_vss_r internal_XL2<2>_vdd_r gnd gnd sg13_lv_nmos w=4.98u l=130.00n m=1
Xinternal_XL2<2>_MP0 internal_XL2<2>_vdd_r internal_XL2<2>_vss_r vdd vdd sg13_lv_pmos w=6.48u l=385.000n m=1
Xinternal_XL2<1>_MN0 internal_XL2<1>_vss_r internal_XL2<1>_vdd_r gnd gnd sg13_lv_nmos w=4.98u l=130.00n m=1
Xinternal_XL2<1>_MP0 internal_XL2<1>_vdd_r internal_XL2<1>_vss_r vdd vdd sg13_lv_pmos w=6.48u l=385.000n m=1
Xinternal_XSEL_XLATCH<3>_MN3 internal_XSEL_XLATCH<3>_QIN internal_XSEL_XLATCH<3>_CPN internal_XSEL_XLATCH<3>_net14 gnd sg13_lv_nmos w=480.00n l=130.00n m=1
Xinternal_XSEL_XLATCH<3>_MN2 internal_XSEL_XLATCH<3>_net14 internal_XSEL_XLATCH<3>_net10 gnd gnd sg13_lv_nmos w=480.00n l=130.00n m=1
Xinternal_XSEL_XLATCH<3>_MN5 internal_XSEL_XLATCH<3>_net21 addr_3 gnd gnd sg13_lv_nmos w=870.00n l=130.00n m=1
Xinternal_XSEL_XLATCH<3>_MN6 internal_XSEL_XLATCH<3>_QIN cs internal_XSEL_XLATCH<3>_net21 gnd sg13_lv_nmos w=870.00n l=130.00n m=1
Xinternal_XSEL_XLATCH<3>_MN1 internal_XSEL_XLATCH<3>_net10 internal_XSEL_XLATCH<3>_QIN gnd gnd sg13_lv_nmos w=480.00n l=130.00n m=1
Xinternal_XSEL_XLATCH<3>_MN0 internal_XSEL_XLATCH<3>_CPN cs gnd gnd sg13_lv_nmos w=480.00n l=130.00n m=1
Xinternal_XSEL_XLATCH<3>_MN4 internal_XSEL_PADR<3> internal_XSEL_XLATCH<3>_QIN gnd gnd sg13_lv_nmos w=980.00n l=130.00n m=1
Xinternal_XSEL_XLATCH<3>_MP2 internal_XSEL_XLATCH<3>_QIN cs internal_XSEL_XLATCH<3>_net16 vdd sg13_lv_pmos w=480.00n l=130.00n m=1
Xinternal_XSEL_XLATCH<3>_MP0 internal_XSEL_XLATCH<3>_CPN cs vdd vdd sg13_lv_pmos w=480.00n l=130.00n m=1
Xinternal_XSEL_XLATCH<3>_MP4 internal_XSEL_PADR<3> internal_XSEL_XLATCH<3>_QIN vdd vdd sg13_lv_pmos w=1.62u l=130.00n m=1
Xinternal_XSEL_XLATCH<3>_MP3 internal_XSEL_XLATCH<3>_net10 internal_XSEL_XLATCH<3>_QIN vdd vdd sg13_lv_pmos w=480.00n l=130.00n m=1
Xinternal_XSEL_XLATCH<3>_MP1 internal_XSEL_XLATCH<3>_net16 internal_XSEL_XLATCH<3>_net10 vdd vdd sg13_lv_pmos w=480.00n l=130.00n m=1
Xinternal_XSEL_XLATCH<3>_MP6 internal_XSEL_XLATCH<3>_QIN internal_XSEL_XLATCH<3>_CPN internal_XSEL_XLATCH<3>_net20 vdd sg13_lv_pmos w=975.000n l=130.00n m=1
Xinternal_XSEL_XLATCH<3>_MP5 internal_XSEL_XLATCH<3>_net20 addr_3 vdd vdd sg13_lv_pmos w=975.000n l=130.00n m=1
Xinternal_XSEL_XLATCH<2>_MN3 internal_XSEL_XLATCH<2>_QIN internal_XSEL_XLATCH<2>_CPN internal_XSEL_XLATCH<2>_net14 gnd sg13_lv_nmos w=480.00n l=130.00n m=1
Xinternal_XSEL_XLATCH<2>_MN2 internal_XSEL_XLATCH<2>_net14 internal_XSEL_XLATCH<2>_net10 gnd gnd sg13_lv_nmos w=480.00n l=130.00n m=1
Xinternal_XSEL_XLATCH<2>_MN5 internal_XSEL_XLATCH<2>_net21 addr_2 gnd gnd sg13_lv_nmos w=870.00n l=130.00n m=1
Xinternal_XSEL_XLATCH<2>_MN6 internal_XSEL_XLATCH<2>_QIN cs internal_XSEL_XLATCH<2>_net21 gnd sg13_lv_nmos w=870.00n l=130.00n m=1
Xinternal_XSEL_XLATCH<2>_MN1 internal_XSEL_XLATCH<2>_net10 internal_XSEL_XLATCH<2>_QIN gnd gnd sg13_lv_nmos w=480.00n l=130.00n m=1
Xinternal_XSEL_XLATCH<2>_MN0 internal_XSEL_XLATCH<2>_CPN cs gnd gnd sg13_lv_nmos w=480.00n l=130.00n m=1
Xinternal_XSEL_XLATCH<2>_MN4 internal_XSEL_PADR<2> internal_XSEL_XLATCH<2>_QIN gnd gnd sg13_lv_nmos w=980.00n l=130.00n m=1
Xinternal_XSEL_XLATCH<2>_MP2 internal_XSEL_XLATCH<2>_QIN cs internal_XSEL_XLATCH<2>_net16 vdd sg13_lv_pmos w=480.00n l=130.00n m=1
Xinternal_XSEL_XLATCH<2>_MP0 internal_XSEL_XLATCH<2>_CPN cs vdd vdd sg13_lv_pmos w=480.00n l=130.00n m=1
Xinternal_XSEL_XLATCH<2>_MP4 internal_XSEL_PADR<2> internal_XSEL_XLATCH<2>_QIN vdd vdd sg13_lv_pmos w=1.62u l=130.00n m=1
Xinternal_XSEL_XLATCH<2>_MP3 internal_XSEL_XLATCH<2>_net10 internal_XSEL_XLATCH<2>_QIN vdd vdd sg13_lv_pmos w=480.00n l=130.00n m=1
Xinternal_XSEL_XLATCH<2>_MP1 internal_XSEL_XLATCH<2>_net16 internal_XSEL_XLATCH<2>_net10 vdd vdd sg13_lv_pmos w=480.00n l=130.00n m=1
Xinternal_XSEL_XLATCH<2>_MP6 internal_XSEL_XLATCH<2>_QIN internal_XSEL_XLATCH<2>_CPN internal_XSEL_XLATCH<2>_net20 vdd sg13_lv_pmos w=975.000n l=130.00n m=1
Xinternal_XSEL_XLATCH<2>_MP5 internal_XSEL_XLATCH<2>_net20 addr_2 vdd vdd sg13_lv_pmos w=975.000n l=130.00n m=1
Xinternal_XSEL_XLATCH<1>_MN3 internal_XSEL_XLATCH<1>_QIN internal_XSEL_XLATCH<1>_CPN internal_XSEL_XLATCH<1>_net14 gnd sg13_lv_nmos w=480.00n l=130.00n m=1
Xinternal_XSEL_XLATCH<1>_MN2 internal_XSEL_XLATCH<1>_net14 internal_XSEL_XLATCH<1>_net10 gnd gnd sg13_lv_nmos w=480.00n l=130.00n m=1
Xinternal_XSEL_XLATCH<1>_MN5 internal_XSEL_XLATCH<1>_net21 addr_1 gnd gnd sg13_lv_nmos w=870.00n l=130.00n m=1
Xinternal_XSEL_XLATCH<1>_MN6 internal_XSEL_XLATCH<1>_QIN cs internal_XSEL_XLATCH<1>_net21 gnd sg13_lv_nmos w=870.00n l=130.00n m=1
Xinternal_XSEL_XLATCH<1>_MN1 internal_XSEL_XLATCH<1>_net10 internal_XSEL_XLATCH<1>_QIN gnd gnd sg13_lv_nmos w=480.00n l=130.00n m=1
Xinternal_XSEL_XLATCH<1>_MN0 internal_XSEL_XLATCH<1>_CPN cs gnd gnd sg13_lv_nmos w=480.00n l=130.00n m=1
Xinternal_XSEL_XLATCH<1>_MN4 internal_XSEL_PADR<1> internal_XSEL_XLATCH<1>_QIN gnd gnd sg13_lv_nmos w=980.00n l=130.00n m=1
Xinternal_XSEL_XLATCH<1>_MP2 internal_XSEL_XLATCH<1>_QIN cs internal_XSEL_XLATCH<1>_net16 vdd sg13_lv_pmos w=480.00n l=130.00n m=1
Xinternal_XSEL_XLATCH<1>_MP0 internal_XSEL_XLATCH<1>_CPN cs vdd vdd sg13_lv_pmos w=480.00n l=130.00n m=1
Xinternal_XSEL_XLATCH<1>_MP4 internal_XSEL_PADR<1> internal_XSEL_XLATCH<1>_QIN vdd vdd sg13_lv_pmos w=1.62u l=130.00n m=1
Xinternal_XSEL_XLATCH<1>_MP3 internal_XSEL_XLATCH<1>_net10 internal_XSEL_XLATCH<1>_QIN vdd vdd sg13_lv_pmos w=480.00n l=130.00n m=1
Xinternal_XSEL_XLATCH<1>_MP1 internal_XSEL_XLATCH<1>_net16 internal_XSEL_XLATCH<1>_net10 vdd vdd sg13_lv_pmos w=480.00n l=130.00n m=1
Xinternal_XSEL_XLATCH<1>_MP6 internal_XSEL_XLATCH<1>_QIN internal_XSEL_XLATCH<1>_CPN internal_XSEL_XLATCH<1>_net20 vdd sg13_lv_pmos w=975.000n l=130.00n m=1
Xinternal_XSEL_XLATCH<1>_MP5 internal_XSEL_XLATCH<1>_net20 addr_1 vdd vdd sg13_lv_pmos w=975.000n l=130.00n m=1
Xinternal_XSEL_XLATCH<0>_MN3 internal_XSEL_XLATCH<0>_QIN internal_XSEL_XLATCH<0>_CPN internal_XSEL_XLATCH<0>_net14 gnd sg13_lv_nmos w=480.00n l=130.00n m=1
Xinternal_XSEL_XLATCH<0>_MN2 internal_XSEL_XLATCH<0>_net14 internal_XSEL_XLATCH<0>_net10 gnd gnd sg13_lv_nmos w=480.00n l=130.00n m=1
Xinternal_XSEL_XLATCH<0>_MN5 internal_XSEL_XLATCH<0>_net21 addr_0 gnd gnd sg13_lv_nmos w=870.00n l=130.00n m=1
Xinternal_XSEL_XLATCH<0>_MN6 internal_XSEL_XLATCH<0>_QIN cs internal_XSEL_XLATCH<0>_net21 gnd sg13_lv_nmos w=870.00n l=130.00n m=1
Xinternal_XSEL_XLATCH<0>_MN1 internal_XSEL_XLATCH<0>_net10 internal_XSEL_XLATCH<0>_QIN gnd gnd sg13_lv_nmos w=480.00n l=130.00n m=1
Xinternal_XSEL_XLATCH<0>_MN0 internal_XSEL_XLATCH<0>_CPN cs gnd gnd sg13_lv_nmos w=480.00n l=130.00n m=1
Xinternal_XSEL_XLATCH<0>_MN4 internal_XSEL_PADR<0> internal_XSEL_XLATCH<0>_QIN gnd gnd sg13_lv_nmos w=980.00n l=130.00n m=1
Xinternal_XSEL_XLATCH<0>_MP2 internal_XSEL_XLATCH<0>_QIN cs internal_XSEL_XLATCH<0>_net16 vdd sg13_lv_pmos w=480.00n l=130.00n m=1
Xinternal_XSEL_XLATCH<0>_MP0 internal_XSEL_XLATCH<0>_CPN cs vdd vdd sg13_lv_pmos w=480.00n l=130.00n m=1
Xinternal_XSEL_XLATCH<0>_MP4 internal_XSEL_PADR<0> internal_XSEL_XLATCH<0>_QIN vdd vdd sg13_lv_pmos w=1.62u l=130.00n m=1
Xinternal_XSEL_XLATCH<0>_MP3 internal_XSEL_XLATCH<0>_net10 internal_XSEL_XLATCH<0>_QIN vdd vdd sg13_lv_pmos w=480.00n l=130.00n m=1
Xinternal_XSEL_XLATCH<0>_MP1 internal_XSEL_XLATCH<0>_net16 internal_XSEL_XLATCH<0>_net10 vdd vdd sg13_lv_pmos w=480.00n l=130.00n m=1
Xinternal_XSEL_XLATCH<0>_MP6 internal_XSEL_XLATCH<0>_QIN internal_XSEL_XLATCH<0>_CPN internal_XSEL_XLATCH<0>_net20 vdd sg13_lv_pmos w=975.000n l=130.00n m=1
Xinternal_XSEL_XLATCH<0>_MP5 internal_XSEL_XLATCH<0>_net20 addr_0 vdd vdd sg13_lv_pmos w=975.000n l=130.00n m=1
Xinternal_XSEL_XI0<3>_MP1 internal_XSEL_sel01<3> internal_XSEL_PADR<0> vdd vdd sg13_lv_pmos w=1.62u l=130.00n m=1
Xinternal_XSEL_XI0<3>_MP0 internal_XSEL_sel01<3> internal_XSEL_PADR<1> vdd vdd sg13_lv_pmos w=1.62u l=130.00n m=1
Xinternal_XSEL_XI0<3>_MN0 internal_XSEL_sel01<3> internal_XSEL_PADR<0> internal_XSEL_XI0<3>_net7 gnd sg13_lv_nmos w=980.00n l=130.00n m=1
Xinternal_XSEL_XI0<3>_MN1 internal_XSEL_XI0<3>_net7 internal_XSEL_PADR<1> gnd gnd sg13_lv_nmos w=980.00n l=130.00n m=1
Xinternal_XSEL_XI0<2>_MP1 internal_XSEL_sel01<2> internal_XSEL_NADR<0> vdd vdd sg13_lv_pmos w=1.62u l=130.00n m=1
Xinternal_XSEL_XI0<2>_MP0 internal_XSEL_sel01<2> internal_XSEL_PADR<1> vdd vdd sg13_lv_pmos w=1.62u l=130.00n m=1
Xinternal_XSEL_XI0<2>_MN0 internal_XSEL_sel01<2> internal_XSEL_NADR<0> internal_XSEL_XI0<2>_net7 gnd sg13_lv_nmos w=980.00n l=130.00n m=1
Xinternal_XSEL_XI0<2>_MN1 internal_XSEL_XI0<2>_net7 internal_XSEL_PADR<1> gnd gnd sg13_lv_nmos w=980.00n l=130.00n m=1
Xinternal_XSEL_XI0<1>_MP1 internal_XSEL_sel01<1> internal_XSEL_PADR<0> vdd vdd sg13_lv_pmos w=1.62u l=130.00n m=1
Xinternal_XSEL_XI0<1>_MP0 internal_XSEL_sel01<1> internal_XSEL_NADR<1> vdd vdd sg13_lv_pmos w=1.62u l=130.00n m=1
Xinternal_XSEL_XI0<1>_MN0 internal_XSEL_sel01<1> internal_XSEL_PADR<0> internal_XSEL_XI0<1>_net7 gnd sg13_lv_nmos w=980.00n l=130.00n m=1
Xinternal_XSEL_XI0<1>_MN1 internal_XSEL_XI0<1>_net7 internal_XSEL_NADR<1> gnd gnd sg13_lv_nmos w=980.00n l=130.00n m=1
Xinternal_XSEL_XI0<0>_MP1 internal_XSEL_sel01<0> internal_XSEL_NADR<0> vdd vdd sg13_lv_pmos w=1.62u l=130.00n m=1
Xinternal_XSEL_XI0<0>_MP0 internal_XSEL_sel01<0> internal_XSEL_NADR<1> vdd vdd sg13_lv_pmos w=1.62u l=130.00n m=1
Xinternal_XSEL_XI0<0>_MN0 internal_XSEL_sel01<0> internal_XSEL_NADR<0> internal_XSEL_XI0<0>_net7 gnd sg13_lv_nmos w=980.00n l=130.00n m=1
Xinternal_XSEL_XI0<0>_MN1 internal_XSEL_XI0<0>_net7 internal_XSEL_NADR<1> gnd gnd sg13_lv_nmos w=980.00n l=130.00n m=1
Xinternal_XSEL_XI4_MN0 internal_XSEL_EN internal_ECLK_B<1> gnd gnd sg13_lv_nmos w=1.41u l=130.00n m=1
Xinternal_XSEL_XI4_MP0 internal_XSEL_EN internal_ECLK_B<1> vdd vdd sg13_lv_pmos w=3.24u l=130.00n m=1
Xinternal_XSEL_XI5_MN0 internal_ECLK_B<1> eclk gnd gnd sg13_lv_nmos w=705.000n l=130.00n m=1
Xinternal_XSEL_XI5_MP0 internal_ECLK_B<1> eclk vdd vdd sg13_lv_pmos w=1.62u l=130.00n m=1
Xinternal_XSEL_XI3<3>_MN0 internal_XSEL_NADR<3> internal_XSEL_PADR<3> gnd gnd sg13_lv_nmos w=980.00n l=130.00n m=1
Xinternal_XSEL_XI3<3>_MP0 internal_XSEL_NADR<3> internal_XSEL_PADR<3> vdd vdd sg13_lv_pmos w=1.62u l=130.00n m=1
Xinternal_XSEL_XI3<2>_MN0 internal_XSEL_NADR<2> internal_XSEL_PADR<2> gnd gnd sg13_lv_nmos w=980.00n l=130.00n m=1
Xinternal_XSEL_XI3<2>_MP0 internal_XSEL_NADR<2> internal_XSEL_PADR<2> vdd vdd sg13_lv_pmos w=1.62u l=130.00n m=1
Xinternal_XSEL_XI3<1>_MN0 internal_XSEL_NADR<1> internal_XSEL_PADR<1> gnd gnd sg13_lv_nmos w=980.00n l=130.00n m=1
Xinternal_XSEL_XI3<1>_MP0 internal_XSEL_NADR<1> internal_XSEL_PADR<1> vdd vdd sg13_lv_pmos w=1.62u l=130.00n m=1
Xinternal_XSEL_XI3<0>_MN0 internal_XSEL_NADR<0> internal_XSEL_PADR<0> gnd gnd sg13_lv_nmos w=980.00n l=130.00n m=1
Xinternal_XSEL_XI3<0>_MP0 internal_XSEL_NADR<0> internal_XSEL_PADR<0> vdd vdd sg13_lv_pmos w=1.62u l=130.00n m=1
Xinternal_XSEL_XI1<3>_MP2 internal_XSEL_sel23<3> internal_XSEL_PADR<2> vdd vdd sg13_lv_pmos w=1.62u l=130.00n m=1
Xinternal_XSEL_XI1<3>_MP1 internal_XSEL_sel23<3> internal_XSEL_PADR<3> vdd vdd sg13_lv_pmos w=1.62u l=130.00n m=1
Xinternal_XSEL_XI1<3>_MP0 internal_XSEL_sel23<3> cs vdd vdd sg13_lv_pmos w=1.62u l=130.00n m=1
Xinternal_XSEL_XI1<3>_MN1 internal_XSEL_XI1<3>_net12 internal_XSEL_PADR<3> internal_XSEL_XI1<3>_net16 gnd sg13_lv_nmos w=980.00n l=130.00n m=1
Xinternal_XSEL_XI1<3>_MN0 internal_XSEL_sel23<3> cs internal_XSEL_XI1<3>_net12 gnd sg13_lv_nmos w=980.00n l=130.00n m=1
Xinternal_XSEL_XI1<3>_MN2 internal_XSEL_XI1<3>_net16 internal_XSEL_PADR<2> gnd gnd sg13_lv_nmos w=980.00n l=130.00n m=1
Xinternal_XSEL_XI1<2>_MP2 internal_XSEL_sel23<2> internal_XSEL_NADR<2> vdd vdd sg13_lv_pmos w=1.62u l=130.00n m=1
Xinternal_XSEL_XI1<2>_MP1 internal_XSEL_sel23<2> internal_XSEL_PADR<3> vdd vdd sg13_lv_pmos w=1.62u l=130.00n m=1
Xinternal_XSEL_XI1<2>_MP0 internal_XSEL_sel23<2> cs vdd vdd sg13_lv_pmos w=1.62u l=130.00n m=1
Xinternal_XSEL_XI1<2>_MN1 internal_XSEL_XI1<2>_net12 internal_XSEL_PADR<3> internal_XSEL_XI1<2>_net16 gnd sg13_lv_nmos w=980.00n l=130.00n m=1
Xinternal_XSEL_XI1<2>_MN0 internal_XSEL_sel23<2> cs internal_XSEL_XI1<2>_net12 gnd sg13_lv_nmos w=980.00n l=130.00n m=1
Xinternal_XSEL_XI1<2>_MN2 internal_XSEL_XI1<2>_net16 internal_XSEL_NADR<2> gnd gnd sg13_lv_nmos w=980.00n l=130.00n m=1
Xinternal_XSEL_XI1<1>_MP2 internal_XSEL_sel23<1> internal_XSEL_PADR<2> vdd vdd sg13_lv_pmos w=1.62u l=130.00n m=1
Xinternal_XSEL_XI1<1>_MP1 internal_XSEL_sel23<1> internal_XSEL_NADR<3> vdd vdd sg13_lv_pmos w=1.62u l=130.00n m=1
Xinternal_XSEL_XI1<1>_MP0 internal_XSEL_sel23<1> cs vdd vdd sg13_lv_pmos w=1.62u l=130.00n m=1
Xinternal_XSEL_XI1<1>_MN1 internal_XSEL_XI1<1>_net12 internal_XSEL_NADR<3> internal_XSEL_XI1<1>_net16 gnd sg13_lv_nmos w=980.00n l=130.00n m=1
Xinternal_XSEL_XI1<1>_MN0 internal_XSEL_sel23<1> cs internal_XSEL_XI1<1>_net12 gnd sg13_lv_nmos w=980.00n l=130.00n m=1
Xinternal_XSEL_XI1<1>_MN2 internal_XSEL_XI1<1>_net16 internal_XSEL_PADR<2> gnd gnd sg13_lv_nmos w=980.00n l=130.00n m=1
Xinternal_XSEL_XI1<0>_MP2 internal_XSEL_sel23<0> internal_XSEL_NADR<2> vdd vdd sg13_lv_pmos w=1.62u l=130.00n m=1
Xinternal_XSEL_XI1<0>_MP1 internal_XSEL_sel23<0> internal_XSEL_NADR<3> vdd vdd sg13_lv_pmos w=1.62u l=130.00n m=1
Xinternal_XSEL_XI1<0>_MP0 internal_XSEL_sel23<0> cs vdd vdd sg13_lv_pmos w=1.62u l=130.00n m=1
Xinternal_XSEL_XI1<0>_MN1 internal_XSEL_XI1<0>_net12 internal_XSEL_NADR<3> internal_XSEL_XI1<0>_net16 gnd sg13_lv_nmos w=980.00n l=130.00n m=1
Xinternal_XSEL_XI1<0>_MN0 internal_XSEL_sel23<0> cs internal_XSEL_XI1<0>_net12 gnd sg13_lv_nmos w=980.00n l=130.00n m=1
Xinternal_XSEL_XI1<0>_MN2 internal_XSEL_XI1<0>_net16 internal_XSEL_NADR<2> gnd gnd sg13_lv_nmos w=980.00n l=130.00n m=1
Xinternal_XSEL_XI2<15>_MP0 internal_XSEL_XI2<15>_net13 internal_XSEL_sel23<3> vdd vdd sg13_lv_pmos w=1.62u l=130.00n m=1
Xinternal_XSEL_XI2<15>_MP2 decode_15 internal_XSEL_EN internal_XSEL_XI2<15>_net10 vdd sg13_lv_pmos w=1.62u l=130.00n m=1
Xinternal_XSEL_XI2<15>_MP1 internal_XSEL_XI2<15>_net10 internal_XSEL_sel01<3> internal_XSEL_XI2<15>_net13 vdd sg13_lv_pmos w=1.62u l=130.00n m=1
Xinternal_XSEL_XI2<15>_MN1 decode_15 internal_XSEL_sel01<3> gnd gnd sg13_lv_nmos w=875.000n l=130.00n m=1
Xinternal_XSEL_XI2<15>_MN0 decode_15 internal_XSEL_EN gnd gnd sg13_lv_nmos w=875.000n l=130.00n m=1
Xinternal_XSEL_XI2<15>_MN2 decode_15 internal_XSEL_sel23<3> gnd gnd sg13_lv_nmos w=875.000n l=130.00n m=1
Xinternal_XSEL_XI2<14>_MP0 internal_XSEL_XI2<14>_net13 internal_XSEL_sel23<3> vdd vdd sg13_lv_pmos w=1.62u l=130.00n m=1
Xinternal_XSEL_XI2<14>_MP2 decode_14 internal_XSEL_EN internal_XSEL_XI2<14>_net10 vdd sg13_lv_pmos w=1.62u l=130.00n m=1
Xinternal_XSEL_XI2<14>_MP1 internal_XSEL_XI2<14>_net10 internal_XSEL_sel01<2> internal_XSEL_XI2<14>_net13 vdd sg13_lv_pmos w=1.62u l=130.00n m=1
Xinternal_XSEL_XI2<14>_MN1 decode_14 internal_XSEL_sel01<2> gnd gnd sg13_lv_nmos w=875.000n l=130.00n m=1
Xinternal_XSEL_XI2<14>_MN0 decode_14 internal_XSEL_EN gnd gnd sg13_lv_nmos w=875.000n l=130.00n m=1
Xinternal_XSEL_XI2<14>_MN2 decode_14 internal_XSEL_sel23<3> gnd gnd sg13_lv_nmos w=875.000n l=130.00n m=1
Xinternal_XSEL_XI2<13>_MP0 internal_XSEL_XI2<13>_net13 internal_XSEL_sel23<3> vdd vdd sg13_lv_pmos w=1.62u l=130.00n m=1
Xinternal_XSEL_XI2<13>_MP2 decode_13 internal_XSEL_EN internal_XSEL_XI2<13>_net10 vdd sg13_lv_pmos w=1.62u l=130.00n m=1
Xinternal_XSEL_XI2<13>_MP1 internal_XSEL_XI2<13>_net10 internal_XSEL_sel01<1> internal_XSEL_XI2<13>_net13 vdd sg13_lv_pmos w=1.62u l=130.00n m=1
Xinternal_XSEL_XI2<13>_MN1 decode_13 internal_XSEL_sel01<1> gnd gnd sg13_lv_nmos w=875.000n l=130.00n m=1
Xinternal_XSEL_XI2<13>_MN0 decode_13 internal_XSEL_EN gnd gnd sg13_lv_nmos w=875.000n l=130.00n m=1
Xinternal_XSEL_XI2<13>_MN2 decode_13 internal_XSEL_sel23<3> gnd gnd sg13_lv_nmos w=875.000n l=130.00n m=1
Xinternal_XSEL_XI2<12>_MP0 internal_XSEL_XI2<12>_net13 internal_XSEL_sel23<3> vdd vdd sg13_lv_pmos w=1.62u l=130.00n m=1
Xinternal_XSEL_XI2<12>_MP2 decode_12 internal_XSEL_EN internal_XSEL_XI2<12>_net10 vdd sg13_lv_pmos w=1.62u l=130.00n m=1
Xinternal_XSEL_XI2<12>_MP1 internal_XSEL_XI2<12>_net10 internal_XSEL_sel01<0> internal_XSEL_XI2<12>_net13 vdd sg13_lv_pmos w=1.62u l=130.00n m=1
Xinternal_XSEL_XI2<12>_MN1 decode_12 internal_XSEL_sel01<0> gnd gnd sg13_lv_nmos w=875.000n l=130.00n m=1
Xinternal_XSEL_XI2<12>_MN0 decode_12 internal_XSEL_EN gnd gnd sg13_lv_nmos w=875.000n l=130.00n m=1
Xinternal_XSEL_XI2<12>_MN2 decode_12 internal_XSEL_sel23<3> gnd gnd sg13_lv_nmos w=875.000n l=130.00n m=1
Xinternal_XSEL_XI2<11>_MP0 internal_XSEL_XI2<11>_net13 internal_XSEL_sel23<2> vdd vdd sg13_lv_pmos w=1.62u l=130.00n m=1
Xinternal_XSEL_XI2<11>_MP2 decode_11 internal_XSEL_EN internal_XSEL_XI2<11>_net10 vdd sg13_lv_pmos w=1.62u l=130.00n m=1
Xinternal_XSEL_XI2<11>_MP1 internal_XSEL_XI2<11>_net10 internal_XSEL_sel01<3> internal_XSEL_XI2<11>_net13 vdd sg13_lv_pmos w=1.62u l=130.00n m=1
Xinternal_XSEL_XI2<11>_MN1 decode_11 internal_XSEL_sel01<3> gnd gnd sg13_lv_nmos w=875.000n l=130.00n m=1
Xinternal_XSEL_XI2<11>_MN0 decode_11 internal_XSEL_EN gnd gnd sg13_lv_nmos w=875.000n l=130.00n m=1
Xinternal_XSEL_XI2<11>_MN2 decode_11 internal_XSEL_sel23<2> gnd gnd sg13_lv_nmos w=875.000n l=130.00n m=1
Xinternal_XSEL_XI2<10>_MP0 internal_XSEL_XI2<10>_net13 internal_XSEL_sel23<2> vdd vdd sg13_lv_pmos w=1.62u l=130.00n m=1
Xinternal_XSEL_XI2<10>_MP2 decode_10 internal_XSEL_EN internal_XSEL_XI2<10>_net10 vdd sg13_lv_pmos w=1.62u l=130.00n m=1
Xinternal_XSEL_XI2<10>_MP1 internal_XSEL_XI2<10>_net10 internal_XSEL_sel01<2> internal_XSEL_XI2<10>_net13 vdd sg13_lv_pmos w=1.62u l=130.00n m=1
Xinternal_XSEL_XI2<10>_MN1 decode_10 internal_XSEL_sel01<2> gnd gnd sg13_lv_nmos w=875.000n l=130.00n m=1
Xinternal_XSEL_XI2<10>_MN0 decode_10 internal_XSEL_EN gnd gnd sg13_lv_nmos w=875.000n l=130.00n m=1
Xinternal_XSEL_XI2<10>_MN2 decode_10 internal_XSEL_sel23<2> gnd gnd sg13_lv_nmos w=875.000n l=130.00n m=1
Xinternal_XSEL_XI2<9>_MP0 internal_XSEL_XI2<9>_net13 internal_XSEL_sel23<2> vdd vdd sg13_lv_pmos w=1.62u l=130.00n m=1
Xinternal_XSEL_XI2<9>_MP2 decode_9 internal_XSEL_EN internal_XSEL_XI2<9>_net10 vdd sg13_lv_pmos w=1.62u l=130.00n m=1
Xinternal_XSEL_XI2<9>_MP1 internal_XSEL_XI2<9>_net10 internal_XSEL_sel01<1> internal_XSEL_XI2<9>_net13 vdd sg13_lv_pmos w=1.62u l=130.00n m=1
Xinternal_XSEL_XI2<9>_MN1 decode_9 internal_XSEL_sel01<1> gnd gnd sg13_lv_nmos w=875.000n l=130.00n m=1
Xinternal_XSEL_XI2<9>_MN0 decode_9 internal_XSEL_EN gnd gnd sg13_lv_nmos w=875.000n l=130.00n m=1
Xinternal_XSEL_XI2<9>_MN2 decode_9 internal_XSEL_sel23<2> gnd gnd sg13_lv_nmos w=875.000n l=130.00n m=1
Xinternal_XSEL_XI2<8>_MP0 internal_XSEL_XI2<8>_net13 internal_XSEL_sel23<2> vdd vdd sg13_lv_pmos w=1.62u l=130.00n m=1
Xinternal_XSEL_XI2<8>_MP2 decode_8 internal_XSEL_EN internal_XSEL_XI2<8>_net10 vdd sg13_lv_pmos w=1.62u l=130.00n m=1
Xinternal_XSEL_XI2<8>_MP1 internal_XSEL_XI2<8>_net10 internal_XSEL_sel01<0> internal_XSEL_XI2<8>_net13 vdd sg13_lv_pmos w=1.62u l=130.00n m=1
Xinternal_XSEL_XI2<8>_MN1 decode_8 internal_XSEL_sel01<0> gnd gnd sg13_lv_nmos w=875.000n l=130.00n m=1
Xinternal_XSEL_XI2<8>_MN0 decode_8 internal_XSEL_EN gnd gnd sg13_lv_nmos w=875.000n l=130.00n m=1
Xinternal_XSEL_XI2<8>_MN2 decode_8 internal_XSEL_sel23<2> gnd gnd sg13_lv_nmos w=875.000n l=130.00n m=1
Xinternal_XSEL_XI2<7>_MP0 internal_XSEL_XI2<7>_net13 internal_XSEL_sel23<1> vdd vdd sg13_lv_pmos w=1.62u l=130.00n m=1
Xinternal_XSEL_XI2<7>_MP2 decode_7 internal_XSEL_EN internal_XSEL_XI2<7>_net10 vdd sg13_lv_pmos w=1.62u l=130.00n m=1
Xinternal_XSEL_XI2<7>_MP1 internal_XSEL_XI2<7>_net10 internal_XSEL_sel01<3> internal_XSEL_XI2<7>_net13 vdd sg13_lv_pmos w=1.62u l=130.00n m=1
Xinternal_XSEL_XI2<7>_MN1 decode_7 internal_XSEL_sel01<3> gnd gnd sg13_lv_nmos w=875.000n l=130.00n m=1
Xinternal_XSEL_XI2<7>_MN0 decode_7 internal_XSEL_EN gnd gnd sg13_lv_nmos w=875.000n l=130.00n m=1
Xinternal_XSEL_XI2<7>_MN2 decode_7 internal_XSEL_sel23<1> gnd gnd sg13_lv_nmos w=875.000n l=130.00n m=1
Xinternal_XSEL_XI2<6>_MP0 internal_XSEL_XI2<6>_net13 internal_XSEL_sel23<1> vdd vdd sg13_lv_pmos w=1.62u l=130.00n m=1
Xinternal_XSEL_XI2<6>_MP2 decode_6 internal_XSEL_EN internal_XSEL_XI2<6>_net10 vdd sg13_lv_pmos w=1.62u l=130.00n m=1
Xinternal_XSEL_XI2<6>_MP1 internal_XSEL_XI2<6>_net10 internal_XSEL_sel01<2> internal_XSEL_XI2<6>_net13 vdd sg13_lv_pmos w=1.62u l=130.00n m=1
Xinternal_XSEL_XI2<6>_MN1 decode_6 internal_XSEL_sel01<2> gnd gnd sg13_lv_nmos w=875.000n l=130.00n m=1
Xinternal_XSEL_XI2<6>_MN0 decode_6 internal_XSEL_EN gnd gnd sg13_lv_nmos w=875.000n l=130.00n m=1
Xinternal_XSEL_XI2<6>_MN2 decode_6 internal_XSEL_sel23<1> gnd gnd sg13_lv_nmos w=875.000n l=130.00n m=1
Xinternal_XSEL_XI2<5>_MP0 internal_XSEL_XI2<5>_net13 internal_XSEL_sel23<1> vdd vdd sg13_lv_pmos w=1.62u l=130.00n m=1
Xinternal_XSEL_XI2<5>_MP2 decode_5 internal_XSEL_EN internal_XSEL_XI2<5>_net10 vdd sg13_lv_pmos w=1.62u l=130.00n m=1
Xinternal_XSEL_XI2<5>_MP1 internal_XSEL_XI2<5>_net10 internal_XSEL_sel01<1> internal_XSEL_XI2<5>_net13 vdd sg13_lv_pmos w=1.62u l=130.00n m=1
Xinternal_XSEL_XI2<5>_MN1 decode_5 internal_XSEL_sel01<1> gnd gnd sg13_lv_nmos w=875.000n l=130.00n m=1
Xinternal_XSEL_XI2<5>_MN0 decode_5 internal_XSEL_EN gnd gnd sg13_lv_nmos w=875.000n l=130.00n m=1
Xinternal_XSEL_XI2<5>_MN2 decode_5 internal_XSEL_sel23<1> gnd gnd sg13_lv_nmos w=875.000n l=130.00n m=1
Xinternal_XSEL_XI2<4>_MP0 internal_XSEL_XI2<4>_net13 internal_XSEL_sel23<1> vdd vdd sg13_lv_pmos w=1.62u l=130.00n m=1
Xinternal_XSEL_XI2<4>_MP2 decode_4 internal_XSEL_EN internal_XSEL_XI2<4>_net10 vdd sg13_lv_pmos w=1.62u l=130.00n m=1
Xinternal_XSEL_XI2<4>_MP1 internal_XSEL_XI2<4>_net10 internal_XSEL_sel01<0> internal_XSEL_XI2<4>_net13 vdd sg13_lv_pmos w=1.62u l=130.00n m=1
Xinternal_XSEL_XI2<4>_MN1 decode_4 internal_XSEL_sel01<0> gnd gnd sg13_lv_nmos w=875.000n l=130.00n m=1
Xinternal_XSEL_XI2<4>_MN0 decode_4 internal_XSEL_EN gnd gnd sg13_lv_nmos w=875.000n l=130.00n m=1
Xinternal_XSEL_XI2<4>_MN2 decode_4 internal_XSEL_sel23<1> gnd gnd sg13_lv_nmos w=875.000n l=130.00n m=1
Xinternal_XSEL_XI2<3>_MP0 internal_XSEL_XI2<3>_net13 internal_XSEL_sel23<0> vdd vdd sg13_lv_pmos w=1.62u l=130.00n m=1
Xinternal_XSEL_XI2<3>_MP2 decode_3 internal_XSEL_EN internal_XSEL_XI2<3>_net10 vdd sg13_lv_pmos w=1.62u l=130.00n m=1
Xinternal_XSEL_XI2<3>_MP1 internal_XSEL_XI2<3>_net10 internal_XSEL_sel01<3> internal_XSEL_XI2<3>_net13 vdd sg13_lv_pmos w=1.62u l=130.00n m=1
Xinternal_XSEL_XI2<3>_MN1 decode_3 internal_XSEL_sel01<3> gnd gnd sg13_lv_nmos w=875.000n l=130.00n m=1
Xinternal_XSEL_XI2<3>_MN0 decode_3 internal_XSEL_EN gnd gnd sg13_lv_nmos w=875.000n l=130.00n m=1
Xinternal_XSEL_XI2<3>_MN2 decode_3 internal_XSEL_sel23<0> gnd gnd sg13_lv_nmos w=875.000n l=130.00n m=1
Xinternal_XSEL_XI2<2>_MP0 internal_XSEL_XI2<2>_net13 internal_XSEL_sel23<0> vdd vdd sg13_lv_pmos w=1.62u l=130.00n m=1
Xinternal_XSEL_XI2<2>_MP2 decode_2 internal_XSEL_EN internal_XSEL_XI2<2>_net10 vdd sg13_lv_pmos w=1.62u l=130.00n m=1
Xinternal_XSEL_XI2<2>_MP1 internal_XSEL_XI2<2>_net10 internal_XSEL_sel01<2> internal_XSEL_XI2<2>_net13 vdd sg13_lv_pmos w=1.62u l=130.00n m=1
Xinternal_XSEL_XI2<2>_MN1 decode_2 internal_XSEL_sel01<2> gnd gnd sg13_lv_nmos w=875.000n l=130.00n m=1
Xinternal_XSEL_XI2<2>_MN0 decode_2 internal_XSEL_EN gnd gnd sg13_lv_nmos w=875.000n l=130.00n m=1
Xinternal_XSEL_XI2<2>_MN2 decode_2 internal_XSEL_sel23<0> gnd gnd sg13_lv_nmos w=875.000n l=130.00n m=1
Xinternal_XSEL_XI2<1>_MP0 internal_XSEL_XI2<1>_net13 internal_XSEL_sel23<0> vdd vdd sg13_lv_pmos w=1.62u l=130.00n m=1
Xinternal_XSEL_XI2<1>_MP2 decode_1 internal_XSEL_EN internal_XSEL_XI2<1>_net10 vdd sg13_lv_pmos w=1.62u l=130.00n m=1
Xinternal_XSEL_XI2<1>_MP1 internal_XSEL_XI2<1>_net10 internal_XSEL_sel01<1> internal_XSEL_XI2<1>_net13 vdd sg13_lv_pmos w=1.62u l=130.00n m=1
Xinternal_XSEL_XI2<1>_MN1 decode_1 internal_XSEL_sel01<1> gnd gnd sg13_lv_nmos w=875.000n l=130.00n m=1
Xinternal_XSEL_XI2<1>_MN0 decode_1 internal_XSEL_EN gnd gnd sg13_lv_nmos w=875.000n l=130.00n m=1
Xinternal_XSEL_XI2<1>_MN2 decode_1 internal_XSEL_sel23<0> gnd gnd sg13_lv_nmos w=875.000n l=130.00n m=1
Xinternal_XSEL_XI2<0>_MP0 internal_XSEL_XI2<0>_net13 internal_XSEL_sel23<0> vdd vdd sg13_lv_pmos w=1.62u l=130.00n m=1
Xinternal_XSEL_XI2<0>_MP2 decode_0 internal_XSEL_EN internal_XSEL_XI2<0>_net10 vdd sg13_lv_pmos w=1.62u l=130.00n m=1
Xinternal_XSEL_XI2<0>_MP1 internal_XSEL_XI2<0>_net10 internal_XSEL_sel01<0> internal_XSEL_XI2<0>_net13 vdd sg13_lv_pmos w=1.62u l=130.00n m=1
Xinternal_XSEL_XI2<0>_MN1 decode_0 internal_XSEL_sel01<0> gnd gnd sg13_lv_nmos w=875.000n l=130.00n m=1
Xinternal_XSEL_XI2<0>_MN0 decode_0 internal_XSEL_EN gnd gnd sg13_lv_nmos w=875.000n l=130.00n m=1
Xinternal_XSEL_XI2<0>_MN2 decode_0 internal_XSEL_sel23<0> gnd gnd sg13_lv_nmos w=875.000n l=130.00n m=1
Xinternal_XSEL_XCAPS4_MN0 internal_XSEL_XCAPS4_vss_r internal_XSEL_XCAPS4_vdd_r gnd gnd sg13_lv_nmos w=2.49u l=130.00n m=1
Xinternal_XSEL_XCAPS4_MP0 internal_XSEL_XCAPS4_vdd_r internal_XSEL_XCAPS4_vss_r vdd vdd sg13_lv_pmos w=3.24u l=385.000n m=1
.ends ihp_row_decoder
